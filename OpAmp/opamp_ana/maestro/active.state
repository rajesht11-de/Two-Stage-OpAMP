ADE simulation setup
Test OpAmp_opamp_ac: OpAmp/opamp_tb/schematic, simulator spectre
  Models: /home/install/FOUNDRY/analog/45nm/gpdk045/../models/spectre/gpdk045.scs[mc]
  Variables: ibias = 10u; vac = 100m; CL = 1p; vdd = 2; vss = 0; vdc = 1
  Temperature: 27
  Analysis ac: start=1 stop=1G dec=10
Test OpAmp_opamp_tb_2: OpAmp/opamp_tb/schematic, simulator spectre
  Models: /home/install/FOUNDRY/analog/45nm/gpdk045/../models/spectre/gpdk045.scs[mc]
  Variables: CL = 1p; ibias = 10u; vdc = 1; vdd = 2; vss = 0
  Temperature: 27
  Analysis tran: stop=100u errpreset=moderate
  Output tpdf = delay(?wf1 VT("/IN") ?value1 1 ?edge1 "rising" ?nth1 1 ?td1 0.0 ?tol1 nil ?wf2 VT("/out") ?value2 1 ?edge2 "falling" ?nth2 1 ?tol2 nil ?td2 nil ?stop nil ?multiple nil)
  Output tpdr = delay(?wf1 VT("/IN") ?value1 1 ?edge1 "falling" ?nth1 1 ?td1 0.0 ?tol1 nil ?wf2 VT("/out") ?value2 1 ?edge2 "rising" ?nth2 1 ?tol2 nil ?td2 nil ?stop nil ?multiple nil)
  Output tpd = ((tpdf + tpdr) / 2)
  Signals: /IN, /out
Test OpAmp_opamp_ac_1: OpAmp/opamp_ac/schematic, simulator spectre
  Models: /home/install/FOUNDRY/analog/45nm/gpdk045/../models/spectre/gpdk045.scs[mc]
  Variables: vac = 100m; CL = 1p; ibias = 10u; vdc = 1; vss = 0; vdd = 2
  Temperature: 27
  Analysis ac: start=1 stop=1G dec=10
  Output gain_db = dB20((VF("/out") / VF("/IN")))
  Output unity gain BW = cross(gain_db 0 1 "falling" nil nil nil)
  Output DC gain = value(gain_db 0 ?scale '(roundDown))
  Signals: /out, /IN
Test OpAmp_opamp_gm_pm_1: OpAmp/opamp_gm_pm/schematic, simulator spectre
  Models: /home/install/FOUNDRY/analog/45nm/gpdk045/../models/spectre/gpdk045.scs[mc]
  Variables: CL = 1p; ibias = 10u; vdc = 1; vdd = 2; vss = 0
  Temperature: 27
  Analysis stb: start=1 stop=1G dec=10 probe=/IPRB0 stbProbeMode=single-ended localgnd=/VSS
Test OpAmp_opamp_tb_1: OpAmp/opamp_tb/schematic, simulator spectre
  Models: /home/install/FOUNDRY/analog/45nm/gpdk045/../models/spectre/gpdk045.scs[tt]
  Variables: CL = 1p; ibias = 10u; vdc = 1; vdd = 2; vss = 0
  Temperature: 27
  Analysis tran: stop=100u errpreset=moderate
  Analysis dc: (saves the operating point)
  Output vout_tran = VT("/out")
  Output vin_tran = VT("/IN")
  Output vout_dc = VDC("/out")
  Output vin_dc = VDC("/IN")
  Output SlewRate = abs(slewRate(vout_tran 1.3 nil 0.7 nil 20 80 nil "time"))
  Output settling_time = settlingTime(vout_tran 0 t 2e-06 t 1 nil "time")
  Output DC_offset = (vout_dc - vin_dc)
  Output power dissipation = abs((2 * IDC("/VDD_source/PLUS")))
  Signals: /out, /IN, /VDD_source/PLUS (terminal)
