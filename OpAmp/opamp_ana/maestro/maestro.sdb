ADE simulation setup
Run mode: Single Run, Sweeps and Corners
Tests:
  OpAmp_opamp_tb_1: OpAmp/opamp_tb/schematic, simulator spectre
    Variables: CL = 1p; ibias = 10u; vdc = 1; vdd = 2; vss = 0
    Outputs: SlewRate; settling_time; DC_offset; power dissipation
  OpAmp_opamp_tb_2: OpAmp/opamp_tb/schematic, simulator spectre
    Variables: CL = 1p; ibias = 10u; vdc = 1; vdd = 2; vss = 0
    Outputs: tpd; tpdf; tpdr
  OpAmp_opamp_ac_1: OpAmp/opamp_ac/schematic, simulator spectre
    Variables: vac = 100m; CL = 1p; ibias = 10u; vdc = 1; vss = 0; vdd = 2
    Outputs: unity gain BW; DC gain
  OpAmp_opamp_gm_pm_1: OpAmp/opamp_gm_pm/schematic, simulator spectre
    Variables: CL = 1p; ibias = 10u; vdc = 1; vdd = 2; vss = 0
Corners (nominal off):
  model folders: /home/install/FOUNDRY/analog/45nm/gpdk045/../models/spectre
  C0: temperature=0,27,80; vdd=1.98,2,2.02; gpdk045.scs[ff]
  C1: temperature=0,27,80; vdd=1.98,2,2.02; gpdk045.scs[fs]
  C2: temperature=0,27,80; vdd=1.98,2,2.02; gpdk045.scs[sf]
  C3: temperature=0,27,80; vdd=1.98,2,2.02; gpdk045.scs[ss]
Specs:
  OpAmp_opamp_tb_1 / SlewRate: > 50M
  OpAmp_opamp_tb_1 / settling_time: < 50n
  OpAmp_opamp_tb_1 / DC_offset: < 10m
  OpAmp_opamp_tb_1 / power dissipation: < 200u
  OpAmp_opamp_ac_1 / unity gain BW: > 50M
  OpAmp_opamp_ac_1 / DC gain: > 50
