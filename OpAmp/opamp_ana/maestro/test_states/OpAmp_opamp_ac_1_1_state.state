ADE simulation setup
Test OpAmp_opamp_ac_1_1: OpAmp/opamp_ac/schematic, simulator spectre
  Models: /home/install/FOUNDRY/analog/45nm/gpdk045/../models/spectre/gpdk045.scs[mc]
  Variables: vac = 100m; CL = 1p; ibias = 10u; vdc = 1; vss = 0; vdd = 2
  Temperature: 27
  Analysis ac: start=1 stop=1G dec=10
  Output gain_db = dB20((VF("/out") / VF("/IN")))
  Output unity gain BW = cross(gain_db 0 1 "falling" nil nil nil)
  Output DC gain = value(gain_db 0 ?scale '(roundDown))
  Signals: /out, /IN
